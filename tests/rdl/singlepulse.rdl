addrmap singlepulse_dev {
    default regwidth = 32;
    reg {
        field { sw = rw; singlepulse; } GO[0:0] = 0;
    } CR @ 0x00;
};
