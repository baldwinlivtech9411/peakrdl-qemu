addrmap overlap_dev {
    default regwidth = 32;
    reg { field { sw = rw; } A[31:0]; } R0 @ 0x00;
    reg { field { sw = rw; } B[31:0]; } R1 @ 0x00;
};
