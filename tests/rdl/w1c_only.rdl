addrmap w1c_only {
    default regwidth = 32;
    reg {
        field { sw = rw; hw = r; onwrite = woclr; } FLAG[0:0] = 0;
        field { sw = rw; hw = r; } EN[1:1] = 0;
    } ST @ 0x00;
};
