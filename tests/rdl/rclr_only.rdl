addrmap rclr_only {
    default regwidth = 32;
    reg {
        field { sw = rw; hw = r; } KEEP[0:0] = 1;
        field { sw = r; hw = r; onread = rclr; } PULSE[1:1] = 0;
    } ST @ 0x00;
};
