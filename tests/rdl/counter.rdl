addrmap counter_dev {
    default regwidth = 32;
    reg {
        field { sw = rw; counter; } CNT[31:0] = 0;
    } COUNT @ 0x00;
};
